* Power-Path: USB ein (1 ms) / aus (6 ms), Last 3V3 30 mA + Motor 80 mA ab 3 ms

.model PMOS_AO3401 PMOS (LEVEL=1 VTO=-0.9 KP=20 RD=0.02 RS=0.02 CGSO=1n CGDO=0.3n IS=1e-12)
.model NMOS_AO3400 NMOS (LEVEL=1 VTO=1.0 KP=30 RD=0.01 RS=0.01 CGSO=0.8n CGDO=0.2n)
.model DSCH D (IS=3e-6 RS=0.08 N=1.05 CJO=100p)   ; B5819W angenaehert (Vf ~0.35 V @ 200 mA)
.model DSIG D (IS=2.5e-9 RS=0.6 N=1.9 CJO=2p)     ; 1N4148W
.model DBODY D (IS=1e-10 RS=0.05 N=1.2)

VBUS vbus_src 0 PWL(0 0 1m 0 1.05m 5 6m 5 6.05m 0)
Rusb vbus_src vbus 0.2
R9 vbus 0 100k
C1 vbus 0 10u
D1 vbus vsys DSCH
* Q1 AO3401A: D=vbat S=vsys G=vbus, Body-Diode vbat->vsys
M1 vbat vbus vsys vsys PMOS_AO3401
DB1 vbat vsys DBODY
Vbat vbatc 0 3.7
Rbat vbatc vbat 0.15
C2 vbat 0 10u
C4 vsys 0 10u
* Q2 Ein/Aus (eingeschaltet, Gate auf GND)
M2 vsw 0 vsys vsys PMOS_AO3401
C5 vsw 0 4.7u
B_LDO 3v3i 0 V = min(3.3, max(0, V(vsw) - 0.15 - 2.5*I(Vsense)))
R_LDOo 3v3i 3v3s 0.05
Vsense 3v3s 3v3 0
C7 3v3 0 6u
Iload 3v3 0 30m
Rmot vsw motd 25
Smot motd 0 mctl 0 SW1
Vmc mctl 0 PWL(0 0 3m 0 3.001m 1)
.model SW1 SW(VT=0.5 RON=0.1 ROFF=1e8)
.tran 2u 9m
.control
run
wrdata /workspace/devices/motion-one/scripts/electronics/../../electronics/spice/powerpath.csv v(vbus) v(vsys) v(vbat) v(3v3) i(Vbat)
meas tran vsys_min_unplug MIN v(vsys) from=6m to=9m
meas tran v3_min_unplug MIN v(3v3) from=6m to=9m
meas tran vsys_usb AVG v(vsys) from=2m to=2.9m
meas tran vsys_bat AVG v(vsys) from=0.5m to=0.9m
meas tran ibat_usb AVG i(Vbat) from=4m to=5.9m
meas tran v3_min_motor MIN v(3v3) from=3m to=4m
.endc
.end
