* Batteriemessteiler: VBAT_EN 0->3.3 V bei 1 ms, aus bei 36 ms, Ausgang Teiler + 100 nF, SAADC-Last

.model PMOS_AO3401 PMOS (LEVEL=1 VTO=-0.9 KP=20 RD=0.02 RS=0.02 CGSO=1n CGDO=0.3n IS=1e-12)
.model NMOS_AO3400 NMOS (LEVEL=1 VTO=1.0 KP=30 RD=0.01 RS=0.01 CGSO=0.8n CGDO=0.2n)
.model DSCH D (IS=3e-6 RS=0.08 N=1.05 CJO=100p)   ; B5819W angenaehert (Vf ~0.35 V @ 200 mA)
.model DSIG D (IS=2.5e-9 RS=0.6 N=1.9 CJO=2p)     ; 1N4148W
.model DBODY D (IS=1e-10 RS=0.05 N=1.2)

Vbat vbat 0 4.2
R11 vbat g 1Meg
M4 top g vbat vbat PMOS_AO3401
M5 g en 0 0 NMOS_AO3400
Ven en 0 PWL(0 0 1m 0 1.001m 3.3 36m 3.3 36.001m 0)
R13 top adc 100k
R14 adc 0 100k
C13 adc 0 100n
.tran 10u 45m
.control
run
wrdata /workspace/devices/motion-one/scripts/electronics/../../electronics/spice/vbat_div.csv v(adc) i(Vbat)
meas tran vadc_settled AVG v(adc) from=33m to=35.9m
meas tran t_settle WHEN v(adc)=2.079 RISE=1
meas tran ioff AVG i(Vbat) from=0.2m to=0.9m
meas tran ion AVG i(Vbat) from=33m to=35.9m
.endc
.end
