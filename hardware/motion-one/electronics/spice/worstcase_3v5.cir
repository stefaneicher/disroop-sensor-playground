* Worst Case: alle Verbraucher, Vbat 3.5 V, Motor 25.5 ohm (30-15 %) Anlauf ab 1 ms, Last 3V3 51.6 mA (nRF TX+8dBm+CPU 39, IMU 0.6, RGB 3x4)

.model PMOS_AO3401 PMOS (LEVEL=1 VTO=-0.9 KP=20 RD=0.02 RS=0.02 CGSO=1n CGDO=0.3n IS=1e-12)
.model NMOS_AO3400 NMOS (LEVEL=1 VTO=1.0 KP=30 RD=0.01 RS=0.01 CGSO=0.8n CGDO=0.2n)
.model DSCH D (IS=3e-6 RS=0.08 N=1.05 CJO=100p)   ; B5819W angenaehert (Vf ~0.35 V @ 200 mA)
.model DSIG D (IS=2.5e-9 RS=0.6 N=1.9 CJO=2p)     ; 1N4148W
.model DBODY D (IS=1e-10 RS=0.05 N=1.2)

Vbat vbatc 0 3.5
Rbat vbatc vsw 0.25
C5 vsw 0 4.7u
B_LDO 3v3i 0 V = min(3.3, max(0, V(vsw) - 0.15 - 2.5*I(Vsense)))
R_LDOo 3v3i 3v3s 0.05
Vsense 3v3s 3v3 0
C7 3v3 0 16.8u
Iload 3v3 0 51.6m
* Summer: 3V3 -> L/R (MLT-5020 ~16 ohm, ANNAHME 0.1 mH) -> R15 22 -> Q6
Lbz 3v3 bzm 100u
Rbz bzm buzn 16
D2 buzn 3v3 DSIG
R15 buzn buzd 22
M6 buzd pwm 0 0 NMOS_AO3400
Vpwm pwm 0 PULSE(0 3.3 0.5m 20n 20n 185u 370u)
* Motor an VSW
Lm vsw m1 30u
Rm m1 motn 25.5
D3 motn vsw DSIG
M7 motn men 0 0 NMOS_AO3400
Vmen men 0 PWL(0 0 1m 0 1.001m 3.3)
.tran 0.5u 5m
.control
run
wrdata /w/electronics/spice/worstcase_3v5.csv v(vsw) v(3v3) i(Vbat)
meas tran v3_min MIN v(3v3) from=0.4m to=5m
meas tran vsw_min MIN v(vsw) from=0.4m to=5m
meas tran ibat_pk MIN i(Vbat) from=1.1m to=5m
meas tran ibat_avg AVG i(Vbat) from=2m to=5m
.endc
.end
